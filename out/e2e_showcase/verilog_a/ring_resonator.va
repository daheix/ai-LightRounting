`include "disciplines.vams"
module ring_resonator_soi (in, through);
  electrical in, through;
  parameter real radius = 1.000000e+01 from (0:inf);
  parameter real neff = 2.400000e+00 from (0:inf);
  parameter real coupling = 1.000000e-02 from [0:1];
  parameter real loss_db_cm = 1.000000e-01 from [0:inf);
  parameter real wavelength = 1.550000e+00 from (0:inf);

  real circumference, beta, phi, a, t, T_real, T_imag;

  analog begin
    circumference = 2.0 * `M_PI * radius;
    beta = 2.0 * `M_PI * neff / wavelength;
    phi = beta * circumference;
    a = pow(10.0, -loss_db_cm * circumference * 1e4 / 20.0);
    t = sqrt(1.0 - coupling);
    // T = (t - a*exp(j*phi)) / (1 - t*a*exp(j*phi))
    T_real = (t - a*cos(phi)) / (1.0 - t*a*cos(phi));
    T_imag = (-a*sin(phi)) / (1.0 - t*a*cos(phi));
    V(through) <+ T_real * V(in);
  end
endmodule
