`include "disciplines.vams"
module mmi_1x2_soI (in, out1, out2);
  electrical in, out1, out2;
  parameter real insertion_loss_db = 4.000000e-01 from [0:inf);
  real amp;

  analog begin
    // 3dB 分束 + 插损
    amp = pow(10.0, -(insertion_loss_db + 3.0) / 20.0);
    V(out1) <+ amp * V(in);
    V(out2) <+ amp * V(in);
  end
endmodule
