`include "disciplines.vams"
module mzm_modulator_soi (in, out, rf_in);
  electrical in, out, rf_in;  // in/out 光学, rf_in 电学驱动
  parameter real v_pi = 3.000000e+00 from (0:inf);     // 半波电压 (V)
  parameter real insertion_loss_db = 5.000000e-01 from [0:inf);
  parameter real efficiency = 1.000000e-01 from [0:inf);  // W/V^2
  real amp, modulation;

  analog begin
    amp = pow(10.0, -insertion_loss_db / 20.0);
    // MZM 传输: T = cos^2(pi*V/(2*V_pi))
    modulation = cos(`M_PI * V(rf_in) / (2.0 * v_pi));
    modulation = modulation * modulation;
    // 光功率输出 = efficiency * V_rf^2 * modulation
    V(out) <+ amp * sqrt(modulation) * V(in);
  end
endmodule
